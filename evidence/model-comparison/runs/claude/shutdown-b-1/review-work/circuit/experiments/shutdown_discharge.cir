* Shutdown discharge check: RC fixture, saved values from /candidate/project/rc_filter.kicad_sch
* Topology from kicad-cli netlist (checks/netlist.json, work/netlist/design.xml):
*   /IN: J1.1, R1.1 ; /OUT: C1.1, J1.2, R1.2 ; GND: C1.2, J1.3
* Scenario: C1 initially 1 V, /IN grounded at t=0, no external load.
* /IN grounded -> node IN tied to 0; ideal passives only.
R1 0 OUT 100k
C1 OUT 0 100n ic=1
.tran 1u 6m uic
.control
run
meas tran vout_at_5ms find v(OUT) at=5m
let tau = 100k*100n
print tau
echo analytic: 1V*exp(-5m/10m) = e^-0.5
wrdata /work/experiments/shutdown_discharge.dat v(OUT)
.endc
.end
