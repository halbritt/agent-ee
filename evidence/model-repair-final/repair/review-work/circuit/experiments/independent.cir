* Independent native-value RC check; grounded, unloaded, zero initial DC
R1 in out 10k
C1 out 0 100n
VSTEP in 0 PWL(0 0 1n 1)
.options reltol=1e-8 abstol=1e-15 vntol=1e-10
.tran 0.5u 5m 0 0.5u
.meas tran vout_1ms find v(out) at=1m
.meas tran vout_5ms find v(out) at=5m
.control
set filetype=ascii
run
write independent.raw
quit
.endc
.end
