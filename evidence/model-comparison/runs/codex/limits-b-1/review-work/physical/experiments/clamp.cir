Scoped R1 continuous clamp calculation; ideal nominal components
Vinput IN 0 DC 48
Vclamp OUT 0 DC 0
R1 IN OUT 10k
C1 OUT 0 100n
.control
op
let r1_voltage = v(IN)-v(OUT)
let r1_current = r1_voltage/10000
let r1_power = r1_voltage*r1_current
print v(IN) v(OUT) r1_current r1_power
quit
.endc
.end
