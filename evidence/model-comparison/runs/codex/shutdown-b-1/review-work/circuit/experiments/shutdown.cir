Ideal shutdown of saved native RC circuit
Vground in 0 DC 0
R1 in out 100k
C1 out 0 100n IC=1
.options reltol=1e-9 abstol=1e-15 vntol=1e-12
.control
tran 10u 50m 0 10u uic
meas tran vout_5ms FIND v(out) AT=5m
meas tran time_to_10mv WHEN v(out)=0.01 FALL=1
set wr_vecnames
set wr_singlescale
wrdata shutdown.tsv v(in) v(out)
quit
.endc
.end
