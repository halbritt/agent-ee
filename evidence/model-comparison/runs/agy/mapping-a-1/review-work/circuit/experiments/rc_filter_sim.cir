* RC Low-Pass Filter Verification (from /candidate/project/rc_filter.kicad_sch)
* External connector J1: pin 1 = /IN, pin 2 = /OUT, pin 3 = GND (0)
V1 in 0 DC 0 AC 1 PULSE(0 1 0 1u 1u 10m 20m)
R1 in out 10k
C1 out 0 100n

.control
op
print v(in) v(out)
ac dec 100 1 100k
meas ac gain_dc FIND vdb(out) AT=1
meas ac f_3db WHEN vdb(out)=-3.0103
meas ac phase_fc FIND vp(out) WHEN vdb(out)=-3.0103
meas ac gain_10k FIND vdb(out) AT=10k
tran 10u 10m
meas tran v_1tau FIND v(out) AT=1m
meas tran v_5tau FIND v(out) AT=5m
quit
.endc
.end
