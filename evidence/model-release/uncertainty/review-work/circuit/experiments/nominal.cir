Nominal unloaded native RC; no ADC model, not a loaded-interface acceptance test
Vin in 0 DC 1
R1 in out 10k
C1 out 0 100n IC=0
.options reltol=1e-8 abstol=1e-12 vntol=1e-10
.tran 0.1u 1.1m 0 0.1u uic
.meas tran out_1ms FIND v(out) AT=1m
.meas tran in_1ms FIND v(in) AT=1m
.end
