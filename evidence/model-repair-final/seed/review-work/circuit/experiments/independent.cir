* Independent native-value unloaded RC response
V1 in 0 PWL(0 0 1m 0 1.000001m 1 6.1m 1)
R1 in out 100k
C1 out 0 100n
.options reltol=1e-8 abstol=1e-14 vntol=1e-10
.tran 1u 6.1m 0 1u
.meas tran vout_1ms FIND v(out) AT=2m
.meas tran vout_5ms FIND v(out) AT=6m
.print tran v(in) v(out)
.end
