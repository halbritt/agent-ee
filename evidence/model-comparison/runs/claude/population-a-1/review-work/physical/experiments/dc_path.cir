* DC continuity of fitted assembly: J1.1(/IN) -R1 10k- J1.2(/OUT), C1 100n to GND
V1 in 0 DC 1
R1 in out 10k
C1 out 0 100n
.op
.control
op
print v(out) v(in) i(v1)
.endc
.end
