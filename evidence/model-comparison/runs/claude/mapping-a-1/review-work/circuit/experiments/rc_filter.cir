* Topology extracted from netlist: J1.1=IN --R1(10k)-- OUT=J1.2, C1(100n) OUT->GND=J1.3
V1 IN 0 AC 1
R1 IN OUT 10k
C1 OUT 0 100n
.control
ac dec 10 1 100k
print vdb(OUT) > rc_ac.txt
let fc_mag = 0.70710678
meas ac vout_at_fc FIND vm(OUT) AT=159.155
quit
.endc
.end
