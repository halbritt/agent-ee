* R1 stress: /IN held at 48V, /OUT clamped to 0V by external equipment
* Netlist per work/netlist/design.xml: R1 pin1=/IN, pin2=/OUT; C1 pin1=/OUT pin2=GND
VIN in 0 DC 48
VCLAMP out 0 DC 0
R1 in out 10k
C1 out 0 100n
.op
.control
op
print v(in) v(out) i(VIN)
let p_r1 = (v(in)-v(out))*(v(in)-v(out))/10000
print p_r1
.endc
.end
