Unloaded nominal RC baseline, not ADC validation
Vin in 0 PWL(0 0 1u 0 1.001u 1 2m 1)
R1 in out 10k
C1 out 0 100n
.tran 0.1u 1.1m 0 0.1u
.measure tran v_out_1ms FIND v(out) AT=1.0010005m
.end
