* Shutdown discharge: C1=100n initially 1V on /OUT, /IN grounded at t=0, no load
* Netlist per work/netlist/design.xml: R1 10k between /IN and /OUT, C1 100n /OUT-GND
* /IN grounded => R1 from OUT to node 0
R1 out 0 10k
C1 out 0 100n IC=1
.tran 1u 6m uic
.control
run
let v5 = v(out)[5000]
print v5
meas tran vout5ms find v(out) at=5m
.endc
.end
