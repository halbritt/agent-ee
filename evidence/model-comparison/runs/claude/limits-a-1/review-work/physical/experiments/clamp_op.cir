* Exercise condition: IN held at 12V, OUT clamped to 0V by external equipment
* Board netlist: R1 (10k) IN-OUT, C1 (100n) OUT-GND
VIN in 0 DC 12
VCLAMP out 0 DC 0
R1 in out 10k
C1 out 0 100n
.op
.control
op
print v(in) v(out) i(vin) i(vclamp)
let p_r1 = (v(in)-v(out))*(-i(vin))
print p_r1
.endc
.end
