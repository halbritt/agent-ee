* R1 DC operating point under external /IN=48V and /OUT=0V clamp
V_IN IN 0 DC 48
V_CLAMP OUT 0 DC 0
R1 IN OUT 10k
C1 OUT 0 100n
.op
.control
op
print v(IN) v(OUT) i(V_IN) @r1[i] @r1[p]
quit
.endc
.end
