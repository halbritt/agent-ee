* Native LS9/LS10 passive reset bias only; NOT a VNL5090 device model.
* Stated +5V rail, R1/R2 =1k pullup, RN1 branch =1k pulldown,
* RN2 branch =1k to driver input. MCU high impedance is the explicit
* reset/undriven condition. No load/current or device switching assumed.
V5 rail 0 DC 5
Rpull rail control 1k
Rdown control 0 1k
Rseries control driver 1k
* No driver input current: unloaded Thevenin bias calculation.
.control
op
print v(control) v(driver)
quit
.endc
.end
