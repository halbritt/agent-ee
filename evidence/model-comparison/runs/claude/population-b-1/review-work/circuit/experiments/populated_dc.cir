* Populated assembly of rc_filter: R1 is DNP (absent); C1 100n fitted OUT-GND.
* Drive /IN with 1V via J1.1; sense DC current reaching /OUT via a 1k load to GND.
* A fitted resistive IN->OUT path would produce ~1V/(Rpath+1k) through RLOAD.
VIN in 0 DC 1
C1 out 0 100n
RLOAD out 0 1k
* (no element between 'in' and 'out': R1 not populated)
.options gmin=1e-15
.op
.control
op
print all
let i_load = v(out)/1k
print i_load
.endc
.end
